// Copyright lowRISC contributors (OpenTitan project).
// Licensed under the Apache License, Version 2.0, see LICENSE for details.
// SPDX-License-Identifier: Apache-2.0
{
  name: "pulser",
  clock_primary: "clk_i",
  reset_primary: "rst_ni"
  // one_line_desc: "Configurable multi-phase multi Pulser pulse generator",
  // one_paragraph_desc: '''
  //   The Pulser peripheral generates sequences of digital pulses based on configurable timing and waveform parameters.
  //   Each instance includes three programmable waveform phases: F1, F2, and STOP. Pulses are generated using programmable
  //   counters for pulse count, duration, and duty cycle. The STOP waveform is always the inverse of the last waveform.
  //   For example, if F2 was high for 4 cycles and stops after 10, Stop will be low for 4 cycles, go to high until it reaches 10.
  // '''
  // // Unique comportable IP identifier defined under KNOWN_CIP_IDS in the regtool.

  bus_interfaces: [
    {
      protocol: "reg_iface",
      direction: "device"
    }
  ],

  regwidth: "32",
  param_list: [
    { name: "NumPulsers",
      desc: "Number of Pulsers",
      type: "int",
      default: "4",
      local: "true"
    }
  ],

  registers: [
    { multireg:
      {
        name: "CFG_F1_END",
        desc: "Phase F1 configuration: end point",
        count: "NumPulsers"
        cname: "CFG_F1_END",
        swaccess: "rw",
        hwaccess: "hro",
        fields: [
          { bits: "15:0",
            name: "ENDVAL",
            desc: "Number of cycles until pulse done (set frequency)"
          }
        ]
      }
    },
    { multireg:
      {
        name: "CFG_F1_SWITCH",
        desc: "Phase F1 configuration: switch points",
        count: "NumPulsers"
        cname: "CFG_F1_SWITCH",
        swaccess: "rw",
        hwaccess: "hro",
        fields: [
          { bits: "15:0",
            name: "SWITCHVAL",
            desc: "Number of cycles until switch (set duty cycle)"
          }
        ]
      }
    },
    { multireg:
      {
        name: "CFG_F2_END",
        desc: "Phase F2 configuration: end point",
        count: "NumPulsers"
        cname: "CFG_F2_END",
        swaccess: "rw",
        hwaccess: "hro",
        fields: [
          { bits: "15:0",
            name: "ENDVAL",
            desc: "Number of cycles until pulse done (set frequency)"
          }
        ]
      }
    },
    { multireg:
      {
        name: "CFG_F2_SWITCH",
        desc: "Phase F2 configuration: switch points",
        count: "NumPulsers"
        cname: "CFG_F2_SWITCH",
        swaccess: "rw",
        hwaccess: "hro",
        fields: [
          { bits: "15:0",
            name: "SWITCHVAL",
            desc: "Number of cycles until switch (set duty cycle)"
          }
        ]
      }
    },
    { multireg:
      {
        name: "CFG_CNT_F1",
        desc: "Configure number of pulses for phase F1",
        count: "NumPulsers"
        cname: "CFG_CNT_F1",
        swaccess: "rw",
        hwaccess: "hro",
        fields: [
          { bits: "7:0",
          name: "F1",
          desc: "Number of f1 pulses"
          }
        ]
      }
    },
    { multireg:
      {
        name: "CFG_CNT_F2",
        desc: "Configure number of pulses for phase F2",
        count: "NumPulsers"
        cname: "CFG_CNT_F2",
        swaccess: "rw",
        hwaccess: "hro",
        fields: [
          { bits: "7:0",
          name: "F2",
          desc: "Number of f2 pulses"
          }
        ]
      }
    },
    { multireg:
      {
        name: "CFG_CNT_STOP",
        desc: "Configure number of pulses for phase STOP",
        count: "NumPulsers"
        cname: "CFG_CNT_STOP",
        swaccess: "rw",
        hwaccess: "hro",
        fields: [
          { bits: "7:0",
          name: "COUNT_STOP",
          desc: "Number of stop pulses"
          }
        ]
      }
    },
    { multireg:
      {
        name: "READY",
        desc: "Read state of pulser",
        count: "NumPulsers"
        cname: "READY",
        swaccess: "ro",
        hwaccess: "hwo",
        fields: [
          { bits: "0",
          name: "READY",
          desc: "High, if pulser is ready to start next pulsing phase"
          }
        ]
      }
    },
    { multireg:
      {
        name: "STATE",
        desc: "Read state of pulser",
        count: "NumPulsers"
        cname: "STATE",
        swaccess: "ro",
        hwaccess: "hwo",
        fields: [
          { bits: "2:0",
          name: "STATE",
          desc: "Current state of the pulser: 0: Idle, 1: Running F1, 2: Running F2, 3: Running Stop pulse, 4: Done."
          }
        ]
      }
    },
    { multireg:
      {
        name: "CTRL_INV_OUT",
        desc: "Set if pulse phase should be inverted",
        count: "NumPulsers"
        cname: "CTRL_INV_OUT",
        swaccess: "rw",
        hwaccess: "hro",
        fields: [
          { bits: "0",
          name: "INVERT_OUT",
          desc: "Set 1, if pulser output should be inverted during pulsing phase."
          }
        ]
      }
    },
    { multireg:
      {
        name: "CTRL_IDLE_OUT",
        desc: "Set idle state of pulser",
        count: "NumPulsers"
        cname: "CTRL_IDLE_OUT",
        swaccess: "rw",
        hwaccess: "hro",
        fields: [
          { bits: "1",
          name: "IDLE_OUT",
          desc: "Control output during idle: 1 to set to 1, 0 to set to 0."
          }
        ]
      }
    },
    { multireg:
      {
        name: "CTRL_START",
        desc: "Start the pulser. No registers generated, commands handled in pulser.",
        count: "NumPulsers"
        cname: "CTRL_START",
        swaccess: "wo",
        hwaccess: "hro",
        hwext: "true",
        hwqe: "true",
        fields: [
          { bits: "0",
          name: "START",
          desc: "Set one to start the pulser."
          }
        ]
      }
    },
    { multireg:
      {
        name: "CTRL_STOP",
        desc: "Stop the pulser. No registers generated, commands handled in pulser.",
        count: "NumPulsers"
        cname: "CTRL_STOP",
        swaccess: "wo",
        hwaccess: "hro",
        hwext: "true",
        hwqe: "true",
        fields: [
          { bits: "1",
          name: "STOP",
          desc: "Set one to stop the pulser."
          }
        ]
      }
    }
  ]
}
