// Copyright 2025 ETH Zurich and University of Bologna.
// Solderpad Hardware License, Version 0.51, see LICENSE for details.
// SPDX-License-Identifier: SHL-0.51
//
// Nico Canzani <ncanzani@student.ethz.ch>

{
  name: "pulser_general",
  clock_primary: "clk_i",
  reset_primary: "rst_ni"
  // one_line_desc: "Configurable multi-phase multi Pulser pulse generator",
  // one_paragraph_desc: '''
  //   The Pulser peripheral generates sequences of digital pulses based on configurable timing and waveform parameters.
  //   Each instance includes three programmable waveform phases: F1, F2, and STOP. Pulses are generated using programmable
  //   counters for pulse count, duration, and duty cycle. The STOP waveform is always the inverse of the last waveform.
  //   For example, if F2 was high for 4 cycles and stops after 10, Stop will be low for 4 cycles, go to high until it reaches 10.
  // '''
  // // Unique comportable IP identifier defined under KNOWN_CIP_IDS in the regtool.

  bus_interfaces: [
    {
      protocol: "reg_iface",
      direction: "device"
    }
  ],

  regwidth: "32",
  registers: [
    {
      name: "CTRL",
      desc: "Start and Stop the pulser. No registers generated, commands handled in pulser.",
      swaccess: "wo",
      hwaccess: "hro",
      hwext: "true",
      hwqe: "true",
      fields: [
        { bits: "15:0",
        name: "START",
        desc: "Set one to start the pulser."
        },
        { bits: "31:16",
        name: "STOP",
        desc: "Set one to stop the pulser."
        }
      ]
    },
    {
      name: "CFG",
      desc: "Set global configs of Pulsers. Currently only enable is active",
      swaccess: "rw",
      hwaccess: "hro",
      fields: [
        { bits: "15:0",
        name: "EN",
        desc: "Activate / Deactivate Pulser (enable / disable clk)."
        }
      ]
    }
  ]
}